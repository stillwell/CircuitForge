RC low-pass filter
* fc = 1 / (2*pi*R*C) ≈ 1.59 kHz
V1 in 0 SIN(0 1 1k 0 0 0)
R1 in out 1k
C1 out 0 100n
.tran 0.01m 5m
.end
