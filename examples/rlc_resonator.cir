RLC series resonator
* f_resonance = 1 / (2*pi*sqrt(LC))
V1 in 0 AC 1
R1 in n1 10
L1 n1 n2 1m
C1 n2 0 1u
.ac dec 50 10 1Meg
.end
